// Picewise model of tunnel diode
`include "disciplines.vams"

module tunnel_diode_v1 (a, c);
    inout a, c;
    electrical a, c;

    real V_q, V_s;

    analog begin
         @(cross(V(a,c)-0.055, 0))
         ;

         @(cross(V(a,c)-0.35, 0))
         ;

        V_q = V(a,c) * V(a,c) * V(a,c);
        V_s = V(a,c) * V(a,c);

        if (V(a,c) < 0.055)
            I(a,c) <+ 6.0105*V_q-0.9917*V_s+0.0545*V(a,c);

        if (V(a,c) >= 0.055 && V(a,c) <= 0.35)
            I(a,c) <+ 0.0692*V_q-0.0421*V_s+0.004*V(a,c)+0.00089579;

        if (V(a,c) > 0.35)
            I(a,c) <+ 0.0692*V_q-0.0421*V_s+0.004*V(a,c)+0.00089579;
    end

endmodule
